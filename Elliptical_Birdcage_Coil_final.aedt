# Ansys Electronics Desktop project, version 2022.1
materials:
  vacuum: permittivity=1
  copper: permeability=0.999991 conductivity=58000000

design HFSSDesign1 (HFSS, DrivenModal, model units mm)
variables:
  D1 = 332.78mm
  D2 = 517.78mm
  coil_height = 400mm
  er_width = 0.5in
  cap_size = 2mm
  separation_angle = 2*pi/num_legs
  a = 0.5*D2
  b = 0.5*D1
  num_legs = 12
  SH1 = 582.26mm
  SH2 = 397.26mm
  SH_height = 460mm
  cap1 = 23.8pF
  cap2 = 21.6pF
  cap3 = 16.8pF
  cap4 = 15.2pF
  cap_leg1 = 16.6pF
  cap_leg2 = 13.3pF
  cap_leg3 = 11pF
  ESR = 0.1ohm  # equivalent series resistance of capacitors
  alpha1 = 0.04884rad
  alpha2 = 0.05925rad
  alpha3 = 0.07394rad
  leg_thickness = 0.3mm
  bore_height = 1000mm
  bore_radius = 300mm
  Zin = 0.1ohm
  Zport = 2ohm
geometry:
  EquationSurface1 = equation_based_surface(XuvFunction=a*cos(_u) YuvFunction=b*sin(_u) ZuvFunction=_v uStart=0 uEnd=pi/2 vStart=0.5*cap_size vEnd=0.5*coil_height)
  TopRing_Cut [non-model] = rectangle(corner=(0mm, 0mm, 0.5*coil_height - er_width), x_size=0.5*D1, y_size=0.5*D2)
  EquationSurface1.split(plane=Rectangle1_1.face, keep=Both)
  Rectangle1_1 = TopRing_Cut.copy()
  Rectangle1_1.delete()
  Capacitor_Cut [vacuum, non-model] = box(corner=(-0.5*cap_size, 0mm, 0.5*coil_height - er_width), size=(cap_size, 300mm, er_width))
  Capacitor_Cut_1, Capacitor_Cut_2, Capacitor_Cut_3 [vacuum, non-model] = Capacitor_Cut.duplicate_around_axis(axis=Z, angle=-separation_angle, total=4)
  EquationSurface1.split(plane=Capacitor_Cut_4.face(6 of 6), keep=NegativeOnly)
  Capacitor_Cut_4 = Capacitor_Cut.copy()
  Capacitor_Cut_4.delete()
  EquationSurface1_Split2 = EquationSurface1.split(plane=Capacitor_Cut_1_1.face(4 of 6), keep=Both)
  Capacitor_Cut_1_1 = Capacitor_Cut_1.copy()
  Capacitor_Cut_1_1.delete()
  EquationSurface1_Split2.split(plane=Capacitor_Cut_1_2.face(6 of 6), keep=NegativeOnly)
  Capacitor_Cut_1_2 = Capacitor_Cut_1.copy()
  Capacitor_Cut_1_2.delete()
  EquationSurface1_Split2_Split1 = EquationSurface1_Split2.split(plane=Capacitor_Cut_2_1.face(4 of 6), keep=Both)
  Capacitor_Cut_2_1 = Capacitor_Cut_2.copy()
  Capacitor_Cut_2_1.delete()
  EquationSurface1_Split2_Split1.split(plane=Capacitor_Cut_2_2.face(6 of 6), keep=NegativeOnly)
  Capacitor_Cut_2_2 = Capacitor_Cut_2.copy()
  Capacitor_Cut_2_2.delete()
  EquationSurface1_Split2_Split1.split(plane=Capacitor_Cut_3_1.face(4 of 6), keep=NegativeOnly)
  Capacitor_Cut_3_1 = Capacitor_Cut_3.copy()
  Capacitor_Cut_3_1.delete()
  coordinate_system RelativeCS1 = origin=(136.94mm, -4.099002mm, 190mm) x=(1mm, 0mm, 0mm) y=(0mm, 1mm, 0mm)
  coordinate_system RelativeCS2 = origin=(-83.217474mm, -79.623524mm, 0mm) x=(1mm, 0mm, 0mm) y=(0mm, 1mm, 0mm) in RelativeCS1
  point Point1 = (239.18317mm, 63.674696mm, 190mm)
  Leg1_Cut [vacuum, non-model] = polyline((0mm, 0mm, 0mm) (340mm, 0mm, 0mm), section rectangle width=coil_height height=0mm orient=Y)
  Leg1_Cut.rotate(axis=Z, angle=0.5*separation_angle)
  Polyline2 = polyline((89.048961mm, 156.23733mm, 0.5*coil_height - er_width) (91.078865mm, 155.75322mm, 0.5*coil_height - er_width) (91.078865mm, 155.75322mm, 0.5*coil_height) (89.048961mm, 156.23733mm, 0.5*coil_height) (89.048961mm, 156.23733mm, 0.5*coil_height - er_width), closed, covered)
  Polyline3 = polyline((191.69721mm, 111.83113mm, 0.5*coil_height) (193.48355mm, 110.55308mm, 0.5*coil_height) (193.48355mm, 110.55308mm, 0.5*coil_height-er_width) (191.69721mm, 111.83113mm, 0.5*coil_height-er_width) (191.69721mm, 111.83113mm, 0.5*coil_height), closed, covered)
  Polyline2_1 = Polyline2.duplicate_mirror(point=(0mm, 0mm, 0mm), normal=(0mm, 0mm, 1mm))
  Polyline3_1 = Polyline3.duplicate_mirror(point=(0mm, 0mm, 0mm), normal=(0mm, 0mm, 1mm))
  EquationSurface1_Split2_1 = EquationSurface1_Split2.duplicate_mirror(point=(0mm, 0mm, 0mm), normal=(0mm, 0mm, 1mm))
  EquationSurface1_Split2_Split1_1 = EquationSurface1_Split2_Split1.duplicate_mirror(point=(0mm, 0mm, 0mm), normal=(0mm, 0mm, 1mm))
  EquationSurface1_1 = EquationSurface1.duplicate_mirror(point=(0mm, 0mm, 0mm), normal=(0mm, 0mm, 1mm))
  Polyline7 [vacuum, non-model] = polyline((0mm, 0mm, -0.5*coil_height + 0.5*er_width) (300mm, 0mm, -0.5*coil_height + 0.5*er_width), section rectangle width=10mm height=0mm orient=Y)
  Polyline7_1, Polyline7_2, Polyline7_3 [vacuum, non-model] = Polyline7.duplicate_around_axis(axis=Z, angle=separation_angle, total=4)
  EquationSurface1_2 = EquationSurface1.duplicate_mirror(point=(0mm, 0mm, 0mm), normal=(1mm, 0mm, 0mm))
  EquationSurface1_Split2_2 = EquationSurface1_Split2.duplicate_mirror(point=(0mm, 0mm, 0mm), normal=(1mm, 0mm, 0mm))
  EquationSurface1_Split2_Split1_2 = EquationSurface1_Split2_Split1.duplicate_mirror(point=(0mm, 0mm, 0mm), normal=(1mm, 0mm, 0mm))
  EquationSurface1_Split2_1_1 = EquationSurface1_Split2_1.duplicate_mirror(point=(0mm, 0mm, 0mm), normal=(1mm, 0mm, 0mm))
  EquationSurface1_Split2_Split1_1_1 = EquationSurface1_Split2_Split1_1.duplicate_mirror(point=(0mm, 0mm, 0mm), normal=(1mm, 0mm, 0mm))
  EquationSurface1_1_1 = EquationSurface1_1.duplicate_mirror(point=(0mm, 0mm, 0mm), normal=(1mm, 0mm, 0mm))
  Polyline2_2 = Polyline2.duplicate_mirror(point=(0mm, 0mm, 0mm), normal=(1mm, 0mm, 0mm))
  Polyline3_2 = Polyline3.duplicate_mirror(point=(0mm, 0mm, 0mm), normal=(1mm, 0mm, 0mm))
  Polyline2_1_1 = Polyline2_1.duplicate_mirror(point=(0mm, 0mm, 0mm), normal=(1mm, 0mm, 0mm))
  Polyline3_1_1 = Polyline3_1.duplicate_mirror(point=(0mm, 0mm, 0mm), normal=(1mm, 0mm, 0mm))
  Polyline8 = polyline(y=166.38876mm, xz: (1mm, -0.5*coil_height + er_width) (-1mm, -0.5*coil_height + er_width) (-1mm, -0.5*coil_height) (1mm, -0.5*coil_height) (1mm, -0.5*coil_height + er_width), closed, covered)
  Polyline2_2_1 = Polyline2_2.duplicate_around_axis(axis=Z, angle=pi rad, total=2)
  Polyline2_2.delete()
  Polyline3_2_1 = Polyline3_2.duplicate_around_axis(axis=Z, angle=pi rad, total=2)
  Polyline3_2.delete()
  Polyline2_1_1_1 = Polyline2_1_1.duplicate_around_axis(axis=Z, angle=pi rad, total=2)
  Polyline2_1_1.delete()
  Polyline3_1_1_1 = Polyline3_1_1.duplicate_around_axis(axis=Z, angle=pi rad, total=2)
  Polyline3_1_1.delete()
  EquationSurface1_3 = EquationSurface1.duplicate_around_axis(axis=Z, angle=pi rad, total=2)
  EquationSurface1_Split2_3 = EquationSurface1_Split2.duplicate_around_axis(axis=Z, angle=pi rad, total=2)
  EquationSurface1_Split2_Split1_3 = EquationSurface1_Split2_Split1.duplicate_around_axis(axis=Z, angle=pi rad, total=2)
  EquationSurface1_Split2_1_2 = EquationSurface1_Split2_1.duplicate_around_axis(axis=Z, angle=pi rad, total=2)
  EquationSurface1_Split2_Split1_1_2 = EquationSurface1_Split2_Split1_1.duplicate_around_axis(axis=Z, angle=pi rad, total=2)
  EquationSurface1_1_2 = EquationSurface1_1.duplicate_around_axis(axis=Z, angle=pi rad, total=2)
  EquationSurface1_2_1 = EquationSurface1_2.duplicate_around_axis(axis=Z, angle=pi rad, total=2)
  EquationSurface1_Split2_2_1 = EquationSurface1_Split2_2.duplicate_around_axis(axis=Z, angle=pi rad, total=2)
  EquationSurface1_Split2_Split1_2_1 = EquationSurface1_Split2_Split1_2.duplicate_around_axis(axis=Z, angle=pi rad, total=2)
  EquationSurface1_Split2_1_1_1 = EquationSurface1_Split2_1_1.duplicate_around_axis(axis=Z, angle=pi rad, total=2)
  EquationSurface1_Split2_Split1_1_1_1 = EquationSurface1_Split2_Split1_1_1.duplicate_around_axis(axis=Z, angle=pi rad, total=2)
  EquationSurface1_1_1_1 = EquationSurface1_1_1.duplicate_around_axis(axis=Z, angle=pi rad, total=2)
  Polyline9 = polyline(x=258.88532mm, yz: (-1mm, -0.5*coil_height + er_width) (1mm, -0.5*coil_height + er_width) (1mm, -0.5*coil_height) (-1mm, -0.5*coil_height) (-1mm, -0.5*coil_height + er_width), closed, covered)
  Polyline10 = polyline(y=166.38876mm, xz: (1mm, 0.5*coil_height) (-1mm, 0.5*coil_height) (-1mm, 0.5*coil_height-er_width) (1mm, 0.5*coil_height-er_width) (1mm, 0.5*coil_height), closed, covered)
  Polyline11 = polyline(x=258.88532mm, yz: (-1mm, 0.5*coil_height) (1mm, 0.5*coil_height) (1mm, 0.5*coil_height - er_width) (-1mm, 0.5*coil_height-er_width) (-1mm, 0.5*coil_height), closed, covered)
  Polyline10_1 = Polyline10.duplicate_around_axis(axis=Z, angle=pi rad, total=2)
  Shield = equation_based_surface(XuvFunction=0.5*SH1*cos(_u) YuvFunction=0.5*SH2*sin(_u) ZuvFunction=_v uStart=0 uEnd=2*pi vStart=-0.5*SH_height vEnd=0.5*SH_height)
  Polyline2_3 = Polyline2.duplicate_around_axis(axis=Z, angle=pi rad, total=2)
  Polyline3_3 = Polyline3.duplicate_around_axis(axis=Z, angle=pi rad, total=2)
  Polyline11_1 = Polyline11.duplicate_around_axis(axis=Z, angle=pi rad, total=2)
  Polyline3_2_1_1 = Polyline3_2_1.duplicate_around_axis(axis=Z, angle=pi rad, total=2)
  Polyline2_2_1_1 = Polyline2_2_1.duplicate_around_axis(axis=Z, angle=pi rad, total=2)
  Polyline2_1_1_1_1 = Polyline2_1_1_1.duplicate_around_axis(axis=Z, angle=pi rad, total=2)
  Polyline3_1_1_1_1 = Polyline3_1_1_1.duplicate_around_axis(axis=Z, angle=pi rad, total=2)
  Polyline2_1_2 = Polyline2_1.duplicate_around_axis(axis=Z, angle=pi rad, total=2)
  Polyline3_1_2 = Polyline3_1.duplicate_around_axis(axis=Z, angle=pi rad, total=2)
  Polyline8_1 = Polyline8.duplicate_around_axis(axis=Z, angle=pi rad, total=2)
  Polyline9_1 = Polyline9.duplicate_around_axis(axis=Z, angle=pi rad, total=2)
  Polyline1_1, Polyline1_2 = Leg1_Cut.duplicate_around_axis(axis=Z, angle=separation_angle, total=3)
  Polyline15 [non-model] = polyline((0mm, 0mm, 0mm) (340mm, 0mm, 0mm))
  Polyline15.rotate(axis=Z, angle=0.5*separation_angle)
  Polyline15_1, Polyline15_2 = Polyline15.duplicate_around_axis(axis=Z, angle=separation_angle, total=3)
  Leg1_Cut.rotate(axis=Z, angle=-0.5*alpha1)
  Polyline1_3 = Leg1_Cut.duplicate_around_axis(axis=Z, angle=alpha1, total=2)
  Leg1_Cut.unite(Polyline1_3)
  Polyline1_1.rotate(axis=Z, angle=-0.5*alpha2)
  Leg2_Cut [vacuum, non-model] = Polyline1_1.duplicate_around_axis(axis=Z, angle=alpha2, total=2)
  Leg2_Cut.unite(Polyline1_1)
  Polyline1_2.rotate(axis=Z, angle=-0.5*alpha3)
  Leg3_Cut [vacuum, non-model] = Polyline1_2.duplicate_around_axis(axis=Z, angle=alpha3, total=2)
  Leg3_Cut.unite(Polyline1_2)
  Leg1_Q1 [copper] = equation_based_surface(XuvFunction=0.5*D2*cos(_u) YuvFunction=0.5*D1*sin(_u) ZuvFunction=_v uStart=0 uEnd=pi/2 vStart="-0.5*coil_height + er_width" vEnd="0.5*coil_height - er_width")
  Leg1_Q1.split(plane=Leg3_Cut_1.face(2 of 2), keep=NegativeOnly)
  Leg3_Cut_1 = Leg3_Cut.copy()
  Leg3_Cut_1.delete()
  Leg3_Q1 [copper] = Leg1_Q1.split(plane=Leg3_Cut_2.face(1 of 2), keep=Both)
  Leg3_Cut_2 = Leg3_Cut.copy()
  Leg3_Cut_2.delete()
  Leg1_Q1.split(plane=Leg2_Cut_1.face(2 of 2), keep=NegativeOnly)
  Leg2_Cut_1 = Leg2_Cut.copy()
  Leg2_Cut_1.delete()
  Leg2_Q1 [copper] = Leg1_Q1.split(plane=Leg2_Cut_2.face(1 of 2), keep=Both)
  Leg2_Cut_2 = Leg2_Cut.copy()
  Leg2_Cut_2.delete()
  Leg1_Q1.split(plane=Leg1_Cut_1.face(1 of 2), keep=NegativeOnly)
  Leg1_Cut_1 = Leg1_Cut.copy()
  Leg1_Cut_1.delete()
  Leg1_Q1.split(plane=Leg1_Cut_2.face(2 of 2), keep=PositiveOnly)
  Leg1_Cut_2 = Leg1_Cut.copy()
  Leg1_Cut_2.delete()
  [Leg1_Q1, Leg3_Q1, Leg2_Q1].thicken(leg_thickness, both sides)
  Leg1_Q1_2 [copper] = Leg1_Q1.duplicate_mirror(point=(0mm, 0mm, 0mm), normal=(0mm, -1mm, 0mm))
  Leg2_Q1_2 [copper] = Leg2_Q1.duplicate_mirror(point=(0mm, 0mm, 0mm), normal=(0mm, -1mm, 0mm))
  Leg3_Q1_2 [copper] = Leg3_Q1.duplicate_mirror(point=(0mm, 0mm, 0mm), normal=(0mm, -1mm, 0mm))
  Leg1_Q1_3 [copper] = Leg1_Q1.duplicate_mirror(point=(0mm, 0mm, 0mm), normal=(-1mm, 0mm, 0mm))
  Leg1_Q1_2_1 [copper] = Leg1_Q1_2.duplicate_mirror(point=(0mm, 0mm, 0mm), normal=(-1mm, 0mm, 0mm))
  Leg2_Q1_3 [copper] = Leg2_Q1.duplicate_mirror(point=(0mm, 0mm, 0mm), normal=(-1mm, 0mm, 0mm))
  Leg2_Q1_2_1 [copper] = Leg2_Q1_2.duplicate_mirror(point=(0mm, 0mm, 0mm), normal=(-1mm, 0mm, 0mm))
  Leg3_Q1_3 [copper] = Leg3_Q1.duplicate_mirror(point=(0mm, 0mm, 0mm), normal=(-1mm, 0mm, 0mm))
  Leg3_Q1_2_1 [copper] = Leg3_Q1_2.duplicate_mirror(point=(0mm, 0mm, 0mm), normal=(-1mm, 0mm, 0mm))
  MRI_bore [vacuum] = cylinder(axis=Z, base_centre=(0mm, 0mm, -0.5*bore_height), radius=bore_radius, height=bore_height, segments=64)
  EquationSurface2 = equation_based_surface(XuvFunction=_u YuvFunction=_v ZuvFunction="(coil_height - 2*er_width)/6" uStart=-0.5*D2 uEnd=0.5*D2 vStart=-0.5*D1 vEnd=0.5*D1)
  EquationSurface2_1 = EquationSurface2.duplicate_mirror(point=(0mm, 0mm, 0mm), normal=(0mm, 0mm, 1mm))
  [EquationSurface2, EquationSurface2_1].thicken(cap_size, both sides)
  EquationSurface2_2 = EquationSurface2.copy()
  EquationSurface2_1_1 = EquationSurface2_1.copy()
  Leg1_Q1.subtract(EquationSurface2_2, EquationSurface2_1_1)
  EquationSurface2_3 = EquationSurface2.copy()
  EquationSurface2_1_2 = EquationSurface2_1.copy()
  Leg1_Q1_2.subtract(EquationSurface2_3, EquationSurface2_1_2)
  EquationSurface2_4 = EquationSurface2.copy()
  EquationSurface2_1_3 = EquationSurface2_1.copy()
  Leg1_Q1_2_1.subtract(EquationSurface2_4, EquationSurface2_1_3)
  EquationSurface2_5 = EquationSurface2.copy()
  EquationSurface2_1_4 = EquationSurface2_1.copy()
  Leg1_Q1_3.subtract(EquationSurface2_5, EquationSurface2_1_4)
  EquationSurface2_6 = EquationSurface2.copy()
  EquationSurface2_1_5 = EquationSurface2_1.copy()
  Leg2_Q1.subtract(EquationSurface2_6, EquationSurface2_1_5)
  EquationSurface2_7 = EquationSurface2.copy()
  EquationSurface2_1_6 = EquationSurface2_1.copy()
  Leg2_Q1_2.subtract(EquationSurface2_7, EquationSurface2_1_6)
  EquationSurface2_8 = EquationSurface2.copy()
  EquationSurface2_1_7 = EquationSurface2_1.copy()
  Leg2_Q1_2_1.subtract(EquationSurface2_8, EquationSurface2_1_7)
  EquationSurface2_9 = EquationSurface2.copy()
  EquationSurface2_1_8 = EquationSurface2_1.copy()
  Leg2_Q1_3.subtract(EquationSurface2_9, EquationSurface2_1_8)
  EquationSurface2_10 = EquationSurface2.copy()
  EquationSurface2_1_9 = EquationSurface2_1.copy()
  Leg3_Q1.subtract(EquationSurface2_10, EquationSurface2_1_9)
  EquationSurface2_11 = EquationSurface2.copy()
  EquationSurface2_1_10 = EquationSurface2_1.copy()
  Leg3_Q1_2.subtract(EquationSurface2_11, EquationSurface2_1_10)
  EquationSurface2_12 = EquationSurface2.copy()
  EquationSurface2_1_11 = EquationSurface2_1.copy()
  Leg3_Q1_2_1.subtract(EquationSurface2_12, EquationSurface2_1_11)
  Leg3_Q1_3.subtract(EquationSurface2, EquationSurface2_1)
  Leg2_upper_cap = polyline(xyz in mm: (-242.29125, -58.620169, 61.433333) (-235.38567, -69.274034, 61.433333) (-235.38567, -69.274034, 63.433333) (-242.29125, -58.620169, 63.433333) (-242.29125, -58.620169, 61.433333), closed, covered)
  Leg3_upper_cap = polyline(xyz in mm: (-145.86299, -137.46689, 61.433333) (-145.86299, -137.46689, 63.433333) (-134.12639, -142.31846, 63.433333) (-134.12639, -142.31846, 61.433333) (-145.86299, -137.46689, 61.433333), closed, covered)
  Leg1_upper_cap = polyline(xyz in mm: (-50.270783, -163.22298, 61.433333) (-50.270783, -163.22298, 63.433333) (-37.64819, -164.62124, 63.433333) (-37.64819, -164.62124, 61.433333) (-50.270783, -163.22298, 61.433333), closed, covered)
  Leg1_lower_cap = Leg1_upper_cap.duplicate_mirror(point=(0mm, 0mm, 0mm), normal=(0mm, 0mm, 1mm))
  Leg2_lower_cap = Leg2_upper_cap.duplicate_mirror(point=(0mm, 0mm, 0mm), normal=(0mm, 0mm, 1mm))
  Leg3_lower_cap = Leg3_upper_cap.duplicate_mirror(point=(0mm, 0mm, 0mm), normal=(0mm, 0mm, 1mm))
  Leg2_upper_cap_1 = Leg2_upper_cap.duplicate_mirror(point=(0mm, 0mm, 0mm), normal=(0mm, -1mm, 0mm))
  Leg3_upper_cap_1 = Leg3_upper_cap.duplicate_mirror(point=(0mm, 0mm, 0mm), normal=(0mm, -1mm, 0mm))
  Leg1_upper_cap_1 = Leg1_upper_cap.duplicate_mirror(point=(0mm, 0mm, 0mm), normal=(0mm, -1mm, 0mm))
  Leg1_lower_cap_1 = Leg1_lower_cap.duplicate_mirror(point=(0mm, 0mm, 0mm), normal=(0mm, -1mm, 0mm))
  Leg2_lower_cap_1 = Leg2_lower_cap.duplicate_mirror(point=(0mm, 0mm, 0mm), normal=(0mm, -1mm, 0mm))
  Leg3_lower_cap_1 = Leg3_lower_cap.duplicate_mirror(point=(0mm, 0mm, 0mm), normal=(0mm, -1mm, 0mm))
  Leg2_upper_cap_2 = Leg2_upper_cap.duplicate_mirror(point=(0mm, 0mm, 0mm), normal=(-1mm, 0mm, 0mm))
  Leg3_upper_cap_2 = Leg3_upper_cap.duplicate_mirror(point=(0mm, 0mm, 0mm), normal=(-1mm, 0mm, 0mm))
  Leg1_upper_cap_2 = Leg1_upper_cap.duplicate_mirror(point=(0mm, 0mm, 0mm), normal=(-1mm, 0mm, 0mm))
  Leg2_upper_cap_1_1 = Leg2_upper_cap_1.duplicate_mirror(point=(0mm, 0mm, 0mm), normal=(-1mm, 0mm, 0mm))
  Leg3_upper_cap_1_1 = Leg3_upper_cap_1.duplicate_mirror(point=(0mm, 0mm, 0mm), normal=(-1mm, 0mm, 0mm))
  Leg1_upper_cap_1_1 = Leg1_upper_cap_1.duplicate_mirror(point=(0mm, 0mm, 0mm), normal=(-1mm, 0mm, 0mm))
  Leg1_lower_cap_2 = Leg1_lower_cap.duplicate_mirror(point=(0mm, 0mm, 0mm), normal=(-1mm, 0mm, 0mm))
  Leg2_lower_cap_2 = Leg2_lower_cap.duplicate_mirror(point=(0mm, 0mm, 0mm), normal=(-1mm, 0mm, 0mm))
  Leg3_lower_cap_2 = Leg3_lower_cap.duplicate_mirror(point=(0mm, 0mm, 0mm), normal=(-1mm, 0mm, 0mm))
  Leg1_lower_cap_1_1 = Leg1_lower_cap_1.duplicate_mirror(point=(0mm, 0mm, 0mm), normal=(-1mm, 0mm, 0mm))
  Leg2_lower_cap_1_1 = Leg2_lower_cap_1.duplicate_mirror(point=(0mm, 0mm, 0mm), normal=(-1mm, 0mm, 0mm))
  Leg3_lower_cap_1_1 = Leg3_lower_cap_1.duplicate_mirror(point=(0mm, 0mm, 0mm), normal=(-1mm, 0mm, 0mm))
  Midplane_Cut [vacuum, non-model] = box(corner=(-260mm, -180mm, -1mm), size=(520mm, 360mm, 2mm))
  Midplane_Cut_1 = Midplane_Cut.copy()
  Leg1_Q1.subtract(Midplane_Cut_1)
  Midplane_Cut_2 = Midplane_Cut.copy()
  Leg1_Q1_2.subtract(Midplane_Cut_2)
  Midplane_Cut_3 = Midplane_Cut.copy()
  Leg1_Q1_2_1.subtract(Midplane_Cut_3)
  Midplane_Cut_4 = Midplane_Cut.copy()
  Leg1_Q1_3.subtract(Midplane_Cut_4)
  Midplane_Cut_5 = Midplane_Cut.copy()
  Leg2_Q1.subtract(Midplane_Cut_5)
  Midplane_Cut_6 = Midplane_Cut.copy()
  Leg2_Q1_2.subtract(Midplane_Cut_6)
  Midplane_Cut_7 = Midplane_Cut.copy()
  Leg2_Q1_2_1.subtract(Midplane_Cut_7)
  Midplane_Cut_8 = Midplane_Cut.copy()
  Leg2_Q1_3.subtract(Midplane_Cut_8)
  Midplane_Cut_9 = Midplane_Cut.copy()
  Leg3_Q1.subtract(Midplane_Cut_9)
  Midplane_Cut_10 = Midplane_Cut.copy()
  Leg3_Q1_2.subtract(Midplane_Cut_10)
  Midplane_Cut_11 = Midplane_Cut.copy()
  Leg3_Q1_2_1.subtract(Midplane_Cut_11)
  Midplane_Cut_12 = Midplane_Cut.copy()
  Leg3_Q1_3.subtract(Midplane_Cut_12)
  Polyline16 = polyline(xyz in mm: (235.38567, -69.274034, -1) (242.29125, -58.620169, -1) (242.29125, -58.620169, 1) (235.38567, -69.274034, 1) (235.38567, -69.274034, -1), closed, covered)
  Polyline17 = polyline(xyz in mm: (145.86299, -137.46689, -1) (134.12639, -142.31846, -1) (134.12639, -142.31846, 1) (145.86299, -137.46689, 1) (145.86299, -137.46689, -1), closed, covered)
  Polyline18 = polyline(xyz in mm: (50.270783, -163.22298, -1) (37.64819, -164.62124, -1) (37.64819, -164.62124, 1) (50.270783, -163.22298, 1) (50.270783, -163.22298, -1), closed, covered)
  Polyline19 = polyline(xyz in mm: (-37.64819, -164.62124, -1) (-50.270783, -163.22298, -1) (-50.270783, -163.22298, 1) (-37.64819, -164.62124, 1) (-37.64819, -164.62124, -1), closed, covered)
  Polyline20 = polyline(xyz in mm: (-134.12639, -142.31846, -1) (-145.86299, -137.46689, -1) (-145.86299, -137.46689, 1) (-134.12639, -142.31846, 1) (-134.12639, -142.31846, -1), closed, covered)
  Polyline21 = polyline(xyz in mm: (-235.38567, -69.274034, -1) (-242.29125, -58.620169, -1) (-242.29125, -58.620169, 1) (-235.38567, -69.274034, 1) (-235.38567, -69.274034, -1), closed, covered)
  Polyline22 = polyline(xyz in mm: (-235.38567, 69.274034, -1) (-242.29125, 58.620169, -1) (-242.29125, 58.620169, 1) (-235.38567, 69.274034, 1) (-235.38567, 69.274034, -1), closed, covered)
  Polyline23 = polyline(xyz in mm: (-134.12639, 142.31846, -1) (-145.86299, 137.46689, -1) (-145.86299, 137.46689, 1) (-134.12639, 142.31846, 1) (-134.12639, 142.31846, -1), closed, covered)
  Polyline24 = polyline(xyz in mm: (-37.64819, 164.62124, -1) (-50.270783, 163.22298, -1) (-50.270783, 163.22298, 1) (-37.64819, 164.62124, 1) (-37.64819, 164.62124, -1), closed, covered)
  Polyline25 = polyline(xyz in mm: (50.270783, 163.22298, -1) (37.64819, 164.62124, -1) (37.64819, 164.62124, 1) (50.270783, 163.22298, 1) (50.270783, 163.22298, -1), closed, covered)
  Polyline26 = polyline(xyz in mm: (145.86299, 137.46689, -1) (134.12639, 142.31846, -1) (134.12639, 142.31846, 1) (145.86299, 137.46689, 1) (145.86299, 137.46689, -1), closed, covered)
  Polyline27 = polyline(xyz in mm: (242.29125, 58.620169, -1) (235.38567, 69.274034, -1) (235.38567, 69.274034, 1) (242.29125, 58.620169, 1) (242.29125, 58.620169, -1), closed, covered)
  Port2 = polyline(x=258.88532mm, yz: (-1mm, 0.5*coil_height) (1mm, 0.5*coil_height) (1mm, 0.5*coil_height - er_width) (-1mm, 0.5*coil_height-er_width) (-1mm, 0.5*coil_height), closed, covered)
  Port2.move(2mm, 0mm, 0mm)
  Port1 = polyline(y=166.38876mm, xz: (1mm, 0.5*coil_height) (-1mm, 0.5*coil_height) (-1mm, 0.5*coil_height-er_width) (1mm, 0.5*coil_height-er_width) (1mm, 0.5*coil_height), closed, covered)
  Port1.move(0mm, 2mm, 0mm)
  Polyline28 [vacuum] = polyline((258.88532mm, -1mm, 193.65mm) (260.88532mm, -1mm, 193.65mm), section rectangle width=er_width height=0mm orient=Y)
  Polyline29 [vacuum] = polyline((260.88532mm, 1mm, 193.65mm) (258.88532mm, 1mm, 193.65mm), section rectangle width=er_width height=0mm orient=Y)
  Polyline30 [vacuum] = polyline((1mm, 166.38876mm, 193.65mm) (1mm, 168.38876mm, 193.65mm), section rectangle width=er_width height=0mm orient=X)
  Polyline31 [vacuum] = polyline((-1mm, 168.38876mm, 193.65mm) (-1mm, 166.38876mm, 193.65mm), section rectangle width=er_width height=0mm orient=X)
  group Capacitor_Cut_Group = Capacitor_Cut, Capacitor_Cut_1, Capacitor_Cut_2, Capacitor_Cut_3
  group Leg_Q1_Group = Leg1_Q1, Leg3_Q1, Leg2_Q1, Leg1_Q1_2, Leg2_Q1_2, Leg3_Q1_2, Leg1_Q1_3, Leg1_Q1_2_1, Leg2_Q1_3, Leg2_Q1_2_1, Leg3_Q1_3, Leg3_Q1_2_1
  group _Cut_Group = TopRing_Cut, Midplane_Cut
  group Bottom_Ring_Cap_Cut = Polyline7, Polyline7_1, Polyline7_2, Polyline7_3
  group Top_Ring_Caps = Polyline2, Polyline3, Polyline2_2_1, Polyline3_2_1, Polyline10, Polyline11, Polyline10_1, Polyline2_3, Polyline3_3, Polyline11_1, Polyline3_2_1_1, Polyline2_2_1_1, Port2, Port1
  group Bottom_Ring_Caps = Polyline2_1_1_1, Polyline3_1_1_1, Polyline2_1_1_1_1, Polyline3_1_1_1_1
  group Bottom_Ring_Ports = Polyline2_1, Polyline3_1, Polyline8, Polyline9, Polyline2_1_2, Polyline3_1_2, Polyline8_1, Polyline9_1
  group Top_Ring = EquationSurface1, EquationSurface1_Split2, EquationSurface1_Split2_Split1, EquationSurface1_2, EquationSurface1_Split2_2, EquationSurface1_Split2_Split1_2, EquationSurface1_3, EquationSurface1_Split2_3, EquationSurface1_Split2_Split1_3, EquationSurface1_2_1, EquationSurface1_Split2_2_1, EquationSurface1_Split2_Split1_2_1
  group Bottom_Ring = EquationSurface1_Split2_1, EquationSurface1_Split2_Split1_1, EquationSurface1_1, EquationSurface1_Split2_1_1, EquationSurface1_Split2_Split1_1_1, EquationSurface1_1_1, EquationSurface1_Split2_1_2, EquationSurface1_Split2_Split1_1_2, EquationSurface1_1_2, EquationSurface1_Split2_1_1_1, EquationSurface1_Split2_Split1_1_1_1, EquationSurface1_1_1_1
  group Leg_Midlines = Polyline15, Polyline15_1, Polyline15_2
  group Leg_Cut = Leg1_Cut, Leg2_Cut, Leg3_Cut
  group Leg_upper_cap = Leg2_upper_cap, Leg3_upper_cap, Leg1_upper_cap, Leg2_upper_cap_1, Leg3_upper_cap_1, Leg1_upper_cap_1, Leg2_upper_cap_2, Leg3_upper_cap_2, Leg1_upper_cap_2, Leg2_upper_cap_1_1, Leg3_upper_cap_1_1, Leg1_upper_cap_1_1
  group Leg_lower_cap = Leg1_lower_cap, Leg2_lower_cap, Leg3_lower_cap, Leg1_lower_cap_1, Leg2_lower_cap_1, Leg3_lower_cap_1, Leg1_lower_cap_2, Leg2_lower_cap_2, Leg3_lower_cap_2, Leg1_lower_cap_1_1, Leg2_lower_cap_1_1, Leg3_lower_cap_1_1
  group Midline_Ports = Polyline16..Polyline27
boundaries and excitations:
  FiniteCond1: Finite Conductivity Objects=[EquationSurface1, EquationSurface1_Split2, EquationSurface1_Split2_Split1, EquationSurface1_Split2_1, EquationSurface1_Split2_Split1_1, EquationSurface1_1, EquationSurface1_2, EquationSurface1_Split2_2, EquationSurface1_Split2_Split1_2, EquationSurface1_Split2_1_1, EquationSurface1_Split2_Split1_1_1, EquationSurface1_1_1, EquationSurface1_3, EquationSurface1_Split2_3, EquationSurface1_Split2_Split1_3, EquationSurface1_Split2_1_2, EquationSurface1_Split2_Split1_1_2, EquationSurface1_1_2, EquationSurface1_2_1, EquationSurface1_Split2_2_1, EquationSurface1_Split2_Split1_2_1, EquationSurface1_Split2_1_1_1, EquationSurface1_Split2_Split1_1_1_1, EquationSurface1_1_1_1] Conductivity=58000000 Permeability=1 Roughness=1um IsInternal
  FiniteCond2: Finite Conductivity Objects=Shield Conductivity=58000000 Permeability=1 Roughness=1um IsInternal
  LumpRLC1: Lumped RLC Objects=Polyline10 CurrentLine{(-1, 166.38876, 193.65) -> (1, 166.38876, 193.65)} RLC_Type=Serial Resistance=ESR Capacitance=cap1
  LumpRLC2: Lumped RLC Objects=Polyline2 CurrentLine{(89.048961, 156.23733, 193.65) -> (91.078865, 155.75322, 193.65)} RLC_Type=Serial Resistance=ESR Capacitance=cap2
  LumpRLC3: Lumped RLC Objects=Polyline3 CurrentLine{(191.69721, 111.83113, 193.65) -> (193.48355, 110.55308, 193.65)} RLC_Type=Serial Resistance=ESR Capacitance=cap3
  LumpRLC4: Lumped RLC Objects=Polyline11 CurrentLine{(258.88532, 1, 193.65) -> (258.88532, -1, 193.65)} RLC_Type=Serial Resistance=ESR Capacitance=cap4
  LumpRLC5: Lumped RLC Objects=Polyline3_2_1 CurrentLine{(193.48355, -110.55308, 193.65) -> (191.69721, -111.83113, 193.65)} RLC_Type=Serial Resistance=ESR Capacitance=cap3
  LumpRLC6: Lumped RLC Objects=Polyline2_2_1 CurrentLine{(91.078865, -155.75322, 193.65) -> (89.048961, -156.23733, 193.65)} RLC_Type=Serial Resistance=ESR Capacitance=cap2
  LumpRLC7: Lumped RLC Objects=Polyline10_1 CurrentLine{(1, -166.38876, 193.65) -> (-1, -166.38876, 193.65)} RLC_Type=Serial Resistance=ESR Capacitance=cap1
  LumpRLC8: Lumped RLC Objects=Polyline2_3 CurrentLine{(-89.048961, -156.23733, 193.65) -> (-91.078865, -155.75322, 193.65)} RLC_Type=Serial Resistance=ESR Capacitance=cap2
  LumpRLC9: Lumped RLC Objects=Polyline3_3 CurrentLine{(-191.69721, -111.83113, 193.65) -> (-193.48355, -110.55308, 193.65)} RLC_Type=Serial Resistance=ESR Capacitance=cap3
  LumpRLC10: Lumped RLC Objects=Polyline11_1 CurrentLine{(-258.88532, -1, 193.65) -> (-258.88532, 1, 193.65)} RLC_Type=Serial Resistance=ESR Capacitance=cap4
  LumpRLC11: Lumped RLC Objects=Polyline3_2_1_1 CurrentLine{(-193.48355, 110.55308, 193.65) -> (-191.69721, 111.83113, 193.65)} RLC_Type=Serial Resistance=ESR Capacitance=cap3
  LumpRLC12: Lumped RLC Objects=Polyline2_2_1_1 CurrentLine{(-91.078865, 155.75322, 193.65) -> (-89.048961, 156.23733, 193.65)} RLC_Type=Serial Resistance=ESR Capacitance=cap2
  LumpRLC_btm5: Lumped RLC Objects=Polyline3_1_1_1 CurrentLine{(191.69721, -111.83113, -193.65) -> (193.48355, -110.55308, -193.65)} RLC_Type=Serial Resistance=ESR Capacitance=cap3
  LumpRLC_btm6: Lumped RLC Objects=Polyline2_1_1_1 CurrentLine{(89.048961, -156.23733, -193.65) -> (91.078865, -155.75322, -193.65)} RLC_Type=Serial Resistance=ESR Capacitance=cap2
  LumpRLC_btm11: Lumped RLC Objects=Polyline3_1_1_1_1 CurrentLine{(-193.48355, 110.55308, -193.65) -> (-191.69721, 111.83113, -193.65)} RLC_Type=Serial Resistance=ESR Capacitance=cap3
  LumpRLC_btm12: Lumped RLC Objects=Polyline2_1_1_1_1 CurrentLine{(-91.078865, 155.75322, -193.65) -> (-89.048961, 156.23733, -193.65)} RLC_Type=Serial Resistance=ESR Capacitance=cap2
  FiniteCond3_Legs: Finite Conductivity Objects=[Leg1_Q1, Leg1_Q1_2, Leg1_Q1_2_1, Leg1_Q1_3, Leg2_Q1, Leg2_Q1_2, Leg2_Q1_2_1, Leg2_Q1_3, Leg3_Q1, Leg3_Q1_2, Leg3_Q1_2_1, Leg3_Q1_3] Conductivity=58000000 Permeability=1 Roughness=1um IsInternal
  LumpRLC13_leg3: Lumped RLC Objects=Leg2_upper_cap CurrentLine{(-238.83846, -63.947102, 63.433333) -> (-238.83846, -63.947102, 61.433333)} RLC_Type=Parallel Resistance=0ohm
  LumpRLC13_leg2: Lumped RLC Objects=Leg3_upper_cap CurrentLine{(-139.99469, -139.89268, 63.433333) -> (-139.99469, -139.89268, 61.433333)} RLC_Type=Parallel Resistance=0ohm
  LumpRLC13_leg1: Lumped RLC Objects=Leg1_upper_cap CurrentLine{(-43.959487, -163.92211, 63.433333) -> (-43.959487, -163.92211, 61.433333)} RLC_Type=Parallel Resistance=0ohm
  LumpRLC13_leg4: Lumped RLC Objects=Leg2_lower_cap CurrentLine{(-238.83846, -63.947102, -63.433333) -> (-238.83846, -63.947102, -61.433333)} RLC_Type=Parallel Resistance=0ohm
  LumpRLC13_leg5: Lumped RLC Objects=Leg3_lower_cap CurrentLine{(-139.99469, -139.89268, -63.433333) -> (-139.99469, -139.89268, -61.433333)} RLC_Type=Parallel Resistance=0ohm
  LumpRLC13_leg6: Lumped RLC Objects=Leg1_lower_cap CurrentLine{(-43.959487, -163.92211, -63.433333) -> (-43.959487, -163.92211, -61.433333)} RLC_Type=Parallel Resistance=0ohm
  LumpRLC13_leg7: Lumped RLC Objects=Leg2_upper_cap_1 CurrentLine{(-238.83846, 63.947102, 63.433333) -> (-238.83846, 63.947102, 61.433333)} RLC_Type=Parallel Resistance=0ohm
  LumpRLC13_leg8: Lumped RLC Objects=Leg3_upper_cap_1 CurrentLine{(-139.99469, 139.89268, 63.433333) -> (-139.99469, 139.89268, 61.433333)} RLC_Type=Parallel Resistance=0ohm
  LumpRLC13_leg9: Lumped RLC Objects=Leg1_upper_cap_1 CurrentLine{(-43.959487, 163.92211, 63.433333) -> (-43.959487, 163.92211, 61.433333)} RLC_Type=Parallel Resistance=0ohm
  LumpRLC13_leg10: Lumped RLC Objects=Leg2_lower_cap_1 CurrentLine{(-238.83846, 63.947102, -63.433333) -> (-238.83846, 63.947102, -61.433333)} RLC_Type=Parallel Resistance=0ohm
  LumpRLC13_leg11: Lumped RLC Objects=Leg3_lower_cap_1 CurrentLine{(-139.99469, 139.89268, -63.433333) -> (-139.99469, 139.89268, -61.433333)} RLC_Type=Parallel Resistance=0ohm
  LumpRLC13_leg12: Lumped RLC Objects=Leg1_lower_cap_1 CurrentLine{(-43.959487, 163.92211, -63.433333) -> (-43.959487, 163.92211, -61.433333)} RLC_Type=Parallel Resistance=0ohm
  LumpRLC13_leg13: Lumped RLC Objects=Leg2_upper_cap_2 CurrentLine{(238.83846, -63.947102, 63.433333) -> (238.83846, -63.947102, 61.433333)} RLC_Type=Parallel Resistance=0ohm
  LumpRLC13_leg14: Lumped RLC Objects=Leg3_upper_cap_2 CurrentLine{(139.99469, -139.89268, 63.433333) -> (139.99469, -139.89268, 61.433333)} RLC_Type=Parallel Resistance=0ohm
  LumpRLC13_leg15: Lumped RLC Objects=Leg1_upper_cap_2 CurrentLine{(43.959487, -163.92211, 63.433333) -> (43.959487, -163.92211, 61.433333)} RLC_Type=Parallel Resistance=0ohm
  LumpRLC13_leg16: Lumped RLC Objects=Leg2_lower_cap_2 CurrentLine{(238.83846, -63.947102, -63.433333) -> (238.83846, -63.947102, -61.433333)} RLC_Type=Parallel Resistance=0ohm
  LumpRLC13_leg17: Lumped RLC Objects=Leg3_lower_cap_2 CurrentLine{(139.99469, -139.89268, -63.433333) -> (139.99469, -139.89268, -61.433333)} RLC_Type=Parallel Resistance=0ohm
  LumpRLC13_leg18: Lumped RLC Objects=Leg1_lower_cap_2 CurrentLine{(43.959487, -163.92211, -63.433333) -> (43.959487, -163.92211, -61.433333)} RLC_Type=Parallel Resistance=0ohm
  LumpRLC13_leg19: Lumped RLC Objects=Leg2_upper_cap_1_1 CurrentLine{(238.83846, 63.947102, 63.433333) -> (238.83846, 63.947102, 61.433333)} RLC_Type=Parallel Resistance=0ohm
  LumpRLC13_leg20: Lumped RLC Objects=Leg3_upper_cap_1_1 CurrentLine{(139.99469, 139.89268, 63.433333) -> (139.99469, 139.89268, 61.433333)} RLC_Type=Parallel Resistance=0ohm
  LumpRLC13_leg21: Lumped RLC Objects=Leg1_upper_cap_1_1 CurrentLine{(43.959487, 163.92211, 63.433333) -> (43.959487, 163.92211, 61.433333)} RLC_Type=Parallel Resistance=0ohm
  LumpRLC13_leg22: Lumped RLC Objects=Leg2_lower_cap_1_1 CurrentLine{(238.83846, 63.947102, -63.433333) -> (238.83846, 63.947102, -61.433333)} RLC_Type=Parallel Resistance=0ohm
  LumpRLC13_leg23: Lumped RLC Objects=Leg3_lower_cap_1_1 CurrentLine{(139.99469, 139.89268, -63.433333) -> (139.99469, 139.89268, -61.433333)} RLC_Type=Parallel Resistance=0ohm
  LumpRLC13_leg24: Lumped RLC Objects=Leg1_lower_cap_1_1 CurrentLine{(43.959487, 163.92211, -63.433333) -> (43.959487, 163.92211, -61.433333)} RLC_Type=Parallel Resistance=0ohm
  LumpRLC_leg2: Lumped RLC Objects=Polyline26 CurrentLine{(139.99469, 139.89268, -1) -> (139.99469, 139.89268, 1)} RLC_Type=Serial Resistance=ESR Capacitance=cap_leg2
  LumpRLC_leg3: Lumped RLC Objects=Polyline27 CurrentLine{(238.83846, 63.947102, -1) -> (238.83846, 63.947102, 1)} RLC_Type=Serial Resistance=ESR Capacitance=cap_leg3
  LumpRLC_leg4: Lumped RLC Objects=Polyline16 CurrentLine{(238.83846, -63.947102, -1) -> (238.83846, -63.947102, 1)} RLC_Type=Serial Resistance=ESR Capacitance=cap_leg3
  LumpRLC_leg5: Lumped RLC Objects=Polyline17 CurrentLine{(139.99469, -139.89268, -1) -> (139.99469, -139.89268, 1)} RLC_Type=Serial Resistance=ESR Capacitance=cap_leg2
  LumpRLC_leg6: Lumped RLC Objects=Polyline18 CurrentLine{(43.959487, -163.92211, -1) -> (43.959487, -163.92211, 1)} RLC_Type=Serial Resistance=ESR Capacitance=cap_leg1
  LumpRLC_leg7: Lumped RLC Objects=Polyline19 CurrentLine{(-43.959487, -163.92211, -1) -> (-43.959487, -163.92211, 1)} RLC_Type=Serial Resistance=ESR Capacitance=cap_leg1
  LumpRLC_leg8: Lumped RLC Objects=Polyline20 CurrentLine{(-139.99469, -139.89268, -1) -> (-139.99469, -139.89268, 1)} RLC_Type=Serial Resistance=ESR Capacitance=cap_leg2
  LumpRLC_leg9: Lumped RLC Objects=Polyline21 CurrentLine{(-238.83846, -63.947102, -1) -> (-238.83846, -63.947102, 1)} RLC_Type=Serial Resistance=ESR Capacitance=cap_leg3
  LumpRLC_leg10: Lumped RLC Objects=Polyline22 CurrentLine{(-238.83846, 63.947102, -1) -> (-238.83846, 63.947102, 1)} RLC_Type=Serial Resistance=ESR Capacitance=cap_leg3
  LumpRLC_leg11: Lumped RLC Objects=Polyline23 CurrentLine{(-139.99469, 139.89268, -1) -> (-139.99469, 139.89268, 1)} RLC_Type=Serial Resistance=ESR Capacitance=cap_leg2
  LumpRLC_leg12: Lumped RLC Objects=Polyline24 CurrentLine{(-43.959487, 163.92211, -1) -> (-43.959487, 163.92211, 1)} RLC_Type=Serial Resistance=ESR Capacitance=cap_leg1
  LumpRLC_leg1: Lumped RLC Objects=Polyline25 CurrentLine{(43.959487, 163.92211, 1) -> (43.959487, 163.92211, -1)} RLC_Type=Serial Resistance=ESR Capacitance=cap_leg1
  LumpRLC_btm1: Lumped RLC Objects=Polyline8 CurrentLine{(1, 166.38876, -193.65) -> (-1, 166.38876, -194)} RLC_Type=Serial Resistance=ESR Capacitance=cap1
  LumpRLC_btm2: Lumped RLC Objects=Polyline2_1 CurrentLine{(91.078865, 155.75322, -193.65) -> (89.048961, 156.23733, -193.65)} RLC_Type=Serial Resistance=ESR Capacitance=cap2
  LumpRLC_btm3: Lumped RLC Objects=Polyline3_1 CurrentLine{(193.48355, 110.55308, -193.65) -> (191.69721, 111.83113, -193.65)} RLC_Type=Serial Resistance=ESR Capacitance=cap3
  LumpRLC_btm4: Lumped RLC Objects=Polyline9 CurrentLine{(258.88532, -1, -193.5) -> (258.88532, 1, -193.5)} RLC_Type=Serial Resistance=ESR Capacitance=cap4
  LumpRLC_btm7: Lumped RLC Objects=Polyline8_1 CurrentLine{(1, -166.38876, -193.65) -> (-1, -166.38876, -193.65)} RLC_Type=Serial Resistance=ESR Capacitance=cap1
  LumpRLC_btm8: Lumped RLC Objects=Polyline2_1_2 CurrentLine{(-91.078865, -155.75322, -193.65) -> (-89.048961, -156.23733, -193.65)} RLC_Type=Serial Resistance=ESR Capacitance=cap2
  LumpRLC_btm9: Lumped RLC Objects=Polyline3_1_2 CurrentLine{(-193.48355, -110.55308, -193.65) -> (-191.69721, -111.83113, -193.65)} RLC_Type=Serial Resistance=ESR Capacitance=cap3
  LumpRLC_btm10: Lumped RLC Objects=Polyline9_1 CurrentLine{(-258.88532, -1, -193.65) -> (-258.88532, 1, -193.65)} RLC_Type=Serial Resistance=ESR Capacitance=cap4
  PerfE1: Perfect E Objects=Polyline28
  PerfE2: Perfect E Objects=Polyline29
  PerfE3: Perfect E Objects=Polyline30
  PerfE4: Perfect E Objects=Polyline31
  1: Lumped Port Objects=Port1 Modes{Mode1{IntLine{(-1, 168.38876, 193.5) -> (1, 168.38876, 193.5)} CharImp=Zpi RenormImp=50ohm}} Impedance=50ohm
  2: Lumped Port Objects=Port2 Modes{Mode1{IntLine{(260.88532, -1, 193.65) -> (260.88532, 1, 193.5)} CharImp=Zpi RenormImp=50ohm}} Impedance=50ohm
mesh:
  Length1: LengthBased RefineInside Objects=MRI_bore MaxLength=100mm
  Length2: LengthBased Objects=[EquationSurface1, EquationSurface1_Split2, EquationSurface1_Split2_Split1, Polyline2, Polyline3, Polyline2_1, Polyline3_1, EquationSurface1_Split2_1, EquationSurface1_Split2_Split1_1, EquationSurface1_1, EquationSurface1_2, EquationSurface1_Split2_2, EquationSurface1_Split2_Split1_2, EquationSurface1_Split2_1_1, EquationSurface1_Split2_Split1_1_1, EquationSurface1_1_1, Polyline8, Polyline2_2_1, Polyline3_2_1, Polyline2_1_1_1, Polyline3_1_1_1, EquationSurface1_3, EquationSurface1_Split2_3, EquationSurface1_Split2_Split1_3, EquationSurface1_Split2_1_2, EquationSurface1_Split2_Split1_1_2, EquationSurface1_1_2, EquationSurface1_2_1, EquationSurface1_Split2_2_1, EquationSurface1_Split2_Split1_2_1, EquationSurface1_Split2_1_1_1, EquationSurface1_Split2_Split1_1_1_1, EquationSurface1_1_1_1, Polyline9, Polyline10, Polyline11, Polyline10_1, Polyline2_3, Polyline3_3, Polyline11_1, Polyline3_2_1_1, Polyline2_2_1_1, Polyline2_1_1_1_1, Polyline3_1_1_1_1, Polyline2_1_2, Polyline3_1_2, Polyline8_1, Polyline9_1, Leg1_Q1, Leg3_Q1, Leg2_Q1, Leg1_Q1_2, Leg2_Q1_2, Leg3_Q1_2, Leg1_Q1_3, Leg1_Q1_2_1, Leg2_Q1_3, Leg2_Q1_2_1, Leg3_Q1_3, Leg3_Q1_2_1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] MaxLength=10mm
  initial mesh: GlobalSurfApproximation{CurvedSurfaceApproxChoice=UseSlider SliderMeshSettings=9} MeshMethod=AnsoftClassic
setups:
  Setup4: HfssDriven Frequency=128MHz MaxDeltaS=0.02 MaximumPasses=10 MinimumPasses=1 MinimumConvergedPasses=3 PercentRefinement=30 BasisOrder=1 PortAccuracy=2 DrivenSolverType="Direct Solver"
    sweep Sweep: 100MHz to 150MHz, 26 points; Type=Discrete
    sweep 123MHz: point 123MHz; SaveSingleField Type=Discrete
  Setup5: HfssDriven Frequency=116MHz MaxDeltaS=0.02 MaximumPasses=6 MinimumPasses=1 MinimumConvergedPasses=1 PercentRefinement=30 BasisOrder=1 PortAccuracy=2 DrivenSolverType="Direct Solver"
    sweep 116MHz: point 116MHz; SaveSingleField Type=Discrete
  Setup6: HfssDrivenAuto AutoSolverSetting=Balanced Type=Discrete
    sweep Sweep: point 134MHz;
  Setup7: HfssDrivenAuto AutoSolverSetting=Balanced Type=Discrete
    sweep Sweep: point 120MHz;
  Setup8: HfssDrivenAuto AutoSolverSetting=Balanced Type=Discrete
    sweep Sweep: point 112MHz;
  Setup9: HfssDriven Frequency=128MHz MaxDeltaS=0.01 MaximumPasses=25 MinimumPasses=1 MinimumConvergedPasses=1 PercentRefinement=30 BasisOrder=1 PortAccuracy=2 DrivenSolverType="Direct Solver"
    sweep Sweep: 100MHz to 150MHz, 26 points; Type=Discrete
    sweep 128MHz: point 128MHz; SaveSingleField Type=Discrete
source amplitudes:
  1:1: 1W 0deg
  2:1: 1W -90deg
optimetrics:
  ParametricSetup1: Parametric
    sweep cap_leg1: LIN 20pF 40pF 10pF
    sweep cap1: 14.2pF
    sweep cap2: 14.2pF
    sweep cap3: 14.2pF
    sweep cap4: 14.2pF
    table edits: edit(20pF, 14.2pF, 14.2pF, 14.2pF, 14.2pF, 20pF, 28.4pF, 14.2pF, 14.2pF, 14.2pF) edit(20pF, 28.4pF, 14.2pF, 14.2pF, 14.2pF, 20pF, 28.4pF, 25.8pF, 14.2pF, 14.2pF) edit(20pF, 28.4pF, 25.8pF, 14.2pF, 14.2pF, 20pF, 28.4pF, 25.8pF, 20.9pF, 14.2pF) edit(20pF, 28.4pF, 25.8pF, 20.9pF, 14.2pF, 20pF, 28.4pF, 25.8pF, 20.9pF, 19.9pF) edit(30pF, 14.2pF, 14.2pF, 14.2pF, 14.2pF, 30pF, 25.6pF, 14.2pF, 14.2pF, 14.2pF) edit(30pF, 25.6pF, 14.2pF, 14.2pF, 14.2pF, 30pF, 25.6pF, 23.1pF, 14.2pF, 14.2pF) edit(30pF, 25.6pF, 23.1pF, 14.2pF, 14.2pF, 30pF, 25.6pF, 23.1pF, 18.9pF, 14.2pF) edit(30pF, 25.6pF, 23.1pF, 18.9pF, 14.2pF, 30pF, 25.6pF, 23.1pF, 18.9pF, 18.3pF) edit(40pF, 14.2pF, 14.2pF, 14.2pF, 14.2pF, 40pF, 23.9pF, 14.2pF, 14.2pF, 14.2pF) edit(40pF, 23.9pF, 14.2pF, 14.2pF, 14.2pF, 40pF, 23.9pF, 21.6pF, 14.2pF, 14.2pF) edit(40pF, 23.9pF, 21.6pF, 14.2pF, 14.2pF, 40pF, 23.9pF, 21.6pF, 18pF, 14.2pF) edit(40pF, 23.9pF, 21.6pF, 18pF, 14.2pF, 40pF, 23.9pF, 21.6pF, 18pF, 17.1pF)
field calculator expressions:
  B1pos = <Hx,Hy,Hz> | ComplexVector_Constant(0.5, 0, 0, 0.5, 0, 0) | Dot | Abs | Real
field plots:
  Mag_H1: H Field over a plane on Setup9 : 128MHz at Freq=128MHz Phase=90
  Mag_Jsurf1: Jsurf over EquationSurface1_1.face(1 of 1) EquationSurface1_1_1.face EquationSurface1_1_1_1.face EquationSurface1_1_2.face EquationSurface1_Split2_1.face(1 of 1) EquationSurface1_Split2_1_1.face EquationSurface1_Split2_1_1_1.face EquationSurface1_Split2_1_2.face EquationSurface1_Split2_Split1_1.face(1 of 1) EquationSurface1_Split2_Split1_1_1.face EquationSurface1_Split2_Split1_1_1_1.face EquationSurface1_Split2_Split1_1_2.face on Setup9 : 128MHz at Freq=0.128GHz Phase=90deg
  Mag_Jsurf2: Jsurf over EquationSurface1.face(1 of 1) EquationSurface1_2.face EquationSurface1_2_1.face EquationSurface1_3.face EquationSurface1_Split2.face(at (212.224, 95.2963, 193.65)) EquationSurface1_Split2_2.face EquationSurface1_Split2_2_1.face EquationSurface1_Split2_3.face EquationSurface1_Split2_Split1.face(at (241.508, 59.9399, 193.65)) EquationSurface1_Split2_Split1_2.face EquationSurface1_Split2_Split1_2_1.face EquationSurface1_Split2_Split1_3.face on Setup9 : 128MHz at Freq=0.128GHz Phase=90deg
  Mag_Jsurf3: Jsurf over Leg1_Q1.face(all 24) Leg1_Q1_2.face(all 24) Leg1_Q1_2_1.face(all 24) Leg1_Q1_3.face(all 24) Leg2_Q1.face(all 24) Leg2_Q1_2.face(all 24) Leg2_Q1_2_1.face(all 24) Leg2_Q1_3.face(all 24) Leg3_Q1.face(all 24) Leg3_Q1_2.face(all 24) Leg3_Q1_2_1.face(all 24) Leg3_Q1_3.face(all 24) on Setup9 : 128MHz at Freq=0.128GHz Phase=90deg
  B1pos1: NamedExpr over a plane on Setup9 : 128MHz at Freq=0.128GHz Phase=0deg
  Vector_H1: H Field over a plane on Setup9 : 128MHz at Freq=0.128GHz Phase=90deg
reports:
  S Parameter Plot 1: dB(S(1,1)), dB(S(2,1)), dB(S(2,2)) vs Freq on Setup9 : Sweep [cap1=all cap2=all cap3=all cap4=all cap_leg1=all]
  Z Parameter Plot 1: re(Z(1,1)), im(Z(1,1)), re(Z(2,1)), im(Z(2,1)), re(Z(2,2)), im(Z(2,2)) vs Freq on Setup9 : Sweep [cap1=all cap2=all cap3=all cap4=all cap_leg1=all]
  Y Parameter Plot 1: re(Y(1,1)), im(Y(1,1)), re(Y(2,1)), im(Y(2,1)), re(Y(2,2)), im(Y(2,2)) vs Freq on Setup9 : Sweep [cap1=all cap2=all cap3=all cap4=all cap_leg1=all]
